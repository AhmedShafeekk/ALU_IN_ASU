ADE simulation setup
Run mode: Single Run, Sweeps and Corners
Tests:
  ALU:ALU_TB:1: ALU/ALU_TB/schematic, simulator spectre
    Outputs: pwr; avgPwr
Global variables:
  WN = 160n
  CLK = 700p
