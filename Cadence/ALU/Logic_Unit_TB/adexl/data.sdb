ADE simulation setup
Run mode: Single Run, Sweeps and Corners
Tests:
  ALU_TEST_BENCHES:LOGIC_UNIT_TB:1: ALU_TEST_BENCHES/LOGIC_UNIT_TB/schematic, simulator spectre
Global variables:
  WN = 1u
